# Ansys Electronics Desktop project, version 2025.2
materials:
  vacuum: permittivity=1
  Mild Steel_20C: permeability{HUnit=A_per_meter BUnit=tesla curve (0, 0) (117.9112, 0.1) (235.742, 0.2) (353.705, 0.3) (471.4946, 0.4) (589.464, 0.5) (707.3321, 0.6) (825, 0.7) (943.2034, 0.8) (1061, 0.9) (1179.5384, 1) (1299, 1.1) (1425, 1.2) (1565, 1.3) (1832.0513, 1.4) (2480.35, 1.5) (3326.2307, 1.6) (4500, 1.7) (5860, 1.8) (7600, 1.9) (11500, 2) (15479, 2.05) (25426, 2.1) (45320, 2.15) (124900, 2.25) (204470, 2.35) (284050, 2.45)} conductivity=6993007 core_loss_type="Electrical Steel" mass_density=7800 core_loss_es_y=2
  N30UH_20C: permeability{BTypeForSingleCurve=intrinsic HUnit=A_per_meter BUnit=tesla curve (-1990000, 0) (-1989534.1, 0.027594435) (-1989057.3, 0.055048307) (-1988569.4, 0.082344301) (-1988070, 0.10946499) (-1987558.9, 0.13639287) (-1987035.9, 0.1631104) (-1986500.6, 0.18960004) (-1985952.8, 0.21584428) (-1985392.1, 0.24182568) (-1984818.4, 0.26752693) (-1984231.2, 0.29293087) (-1983630.2, 0.31802056) (-1983015.2, 0.34277929) (-1982385.8, 0.36719067) (-1981741.7, 0.39123862) (-1981082.4, 0.41490749) (-1980407.8, 0.43818203) (-1979717.3, 0.46104749) (-1979010.7, 0.48348965) (-1978287.6, 0.50549488) (-1977547.5, 0.52705015) (-1976790, 0.54814311) (-1976014.9, 0.56876214) (-1975221.6, 0.58889635) (-1974409.7, 0.60853566) (-1973578.8, 0.62767084) (-1972728.5, 0.64629352) (-1971858.3, 0.66439623) (-1970967.7, 0.68197245) (-1970056.2, 0.69901663) (-1969123.4, 0.71552421) (-1968168.8, 0.73149164) (-1967191.8, 0.74691641) (-1966191.9, 0.76179704) (-1965168.7, 0.77613312) (-1964121.4, 0.78992529) (-1963049.7, 0.80317526) (-1961952.9, 0.81588576) (-1960830.4, 0.8280606) (-1959681.6, 0.83970461) (-1958505.9, 0.85082362) (-1957302.7, 0.86142444) (-1956071.3, 0.87151486) (-1954811.1, 0.88110357) (-1953521.4, 0.89020014) (-1952201.5, 0.89881499) (-1950850.7, 0.90695933) (-1949468.3, 0.9146451) (-1948053.5, 0.92188493) (-1946605.5, 0.92869207) (-1945123.7, 0.93508035) (-1943607.2, 0.94106407) (-1942055.2, 0.94665798) (-1940466.9, 0.9518772) (-1938841.4, 0.95673713) (-1937177.8, 0.96125341) (-1935475.2, 0.96544182) (-1933732.9, 0.96931824) (-1931949.7, 0.97289857) (-1930124.8, 0.97619864) (-1928257.1, 0.9792342) (-1926345.7, 0.98202079) (-1924389.6, 0.98457374) (-1922387.7, 0.98690807) (-1920338.9, 0.98903847) (-1918242.2, 0.99097924) (-1916096.3, 0.99274424) (-1913900.2, 0.99434685) (-1911652.7, 0.99579995) (-1909352.6, 0.9971159) (-1906998.7, 0.99830646) (-1904589.6, 0.99938285) (-1902124.2, 1.0003557) (-1899601, 1.001235) (-1897018.7, 1.0020301) (-1894376, 1.0027499) (-1891671.4, 1.0034026) (-1888903.5, 1.0039958) (-1886070.8, 1.0045366) (-1883171.8, 1.0050313) (-1880204.9, 1.0054861) (-1877168.6, 1.0059062) (-1874061.2, 1.0062967) (-1870881, 1.006662) (-1867626.4, 1.0070061) (-1864295.5, 1.0073327) (-1860886.7, 1.0076449) (-1857398.1, 1.0079457) (-1853827.8, 1.0082376) (-1850174, 1.0085229) (-1846434.6, 1.0088035) (-1842607.6, 1.0090812) (-1838691.1, 1.0093575) (-1834682.8, 1.0096338) (-1830580.7, 1.0099111) (-1826382.6, 1.0101905) (-1822086.2, 1.0104728) (-1817689.2, 1.0107589) (-1813189.3, 1.0110493) (-1808584, 1.0113446) (-1803871, 1.0116453) (-1799047.5, 1.0119519) (-1794111.2, 1.0122648) (-1789059.3, 1.0125843) (-1783889.1, 1.0129107) (-1778597.8, 1.0132443) (-1773182.7, 1.0135854) (-1767640.8, 1.0139342) (-1761969.2, 1.0142911) (-1756164.8, 1.0146561) (-1750224.5, 1.0150296) (-1744145.1, 1.0154117) (-1737923.4, 1.0158028) (-1731556.1, 1.0162029) (-1725039.7, 1.0166124) (-1718370.7, 1.0170315) (-1711545.6, 1.0174604) (-1704560.7, 1.0178993) (-1697412.3, 1.0183484)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} conductivity=555555.56 magnetic_coercivity{Magnitude=-1990000A_per_meter DirComp1=1 DirComp2=0 DirComp3=0}
  M350-50A_20C: permeability{HUnit=A_per_meter BUnit=tesla curve (0, 0) (34.8, 0.1) (46, 0.2) (53.7, 0.3) (60.6, 0.4) (67.4, 0.5) (74.6, 0.6) (82.6, 0.7) (91.8, 0.8) (103, 0.9) (119, 1) (141, 1.1) (178, 1.2) (250, 1.3) (455, 1.4) (1180, 1.5) (3020, 1.6) (6100, 1.7) (10700, 1.8) (25000, 1.9) (35000, 1.956) (75000, 2.1) (115000, 2.2) (150000, 2.2701) (229580, 2.4)} conductivity=2272727.3 core_loss_type="Electrical Steel" core_loss_kh=159.9615 core_loss_kc=0.93462163 mass_density=7650 stacking_type=Lamination stacking_factor=0.97 stacking_direction=V(3) core_loss_es_y=2
  Copper (Annealed)_40C: conductivity=53777712

design Motor-CAD 10020 Halbach (Maxwell 3D, Transient, model units mm)
variables:
  Is_2D_Design = 0
  DiaGap = 100mm
  DiaStatorYoke = 78mm
  DiaShaft = 25mm
  DiaShaft_Effective = 78mm
  DiaOuter = 117mm
  Airgap = 0.5mm
  StatorSkewAngle = 0deg
  Model_Length = 32.081719mm
  Magnet_Length = 10mm
  Stator_Lam_Length = 10mm
  Rotor_Lam_Length = 10mm
  RotorDia = 101mm
  Rotor_Slices = 1
  SlotNumber_Stator = 36
  SlotType_Stator = 3
  Hs0_Stator = 0.5mm
  Hs1_Stator = 0.46310394mm
  Hs2_Stator = 8.8385619mm
  Bs0_Stator = 2.511mm
  Bs1_Stator = 5.9676549mm
  Bs2_Stator = 4.4211069mm
  Rs_Stator = 0.2mm
  FilletType_Stator = 3
  EndWindingLength = 5.1464091mm
  Layers = 2
  ParallelPaths = 1
  SpanExt = 2.5732045mm
  WdgExt_Avg = 0mm
  HalfAxial = 0
  SymmetryFactor = 3
  SegAngle = 0deg
  SegAngle_Coil_Armature = 10deg
  NumPoles = 42
  Magnet_Axial_Offset = 0mm
  Axial_Segments = 1
  DiaAxle = 78mm
  Gap_Shaft_Axle = 2mm
  Shaft_Hole_Diameter = 0mm
  Sleeve_Thickness = 0mm
  Banding_Thickness = 0mm
  IPeak = 22.93276A
  PhaseAdvance = 0deg
  MachineRPM = 500rpm
  Vpeak = 31.902462V
  Rphase = 0.029861553ohm
  PhasorAngle = 42.122934deg
  MaxPhasorAngle = 120deg
  PeakDriveVoltage = Vpeak / (2*sin(MaxPhasorAngle / 2))
  Lend = 1.7751303e-06H
  NumTorqueCycles = 1
  NumTorquePointsPerCycle = 30
  DriveOffsetED = 135deg
  InitialPositionMD = -DriveOffsetED / (NumPoles/2)
geometry:
  Rotor_1 [Mild Steel_20C] = circle(normal=Z, centre=(0mm, 0mm, 0mm), radius=58.5mm)
  Rotor_Subtract_6 = circle(normal=Z, centre=(0mm, 0mm, 0mm), radius=53.5mm)
  Rotor_1.subtract(Rotor_Subtract_6)
  1Magnet1_1_1 [N30UH_20C] = polyline(z=0mm, xy in mm: (-53.2522, -5.1425) (-50.2524, -4.9938) (-50.4999, 0) (-53.4997, -0.1486) (-53.2522, -5.1425), closed, covered)
  2Magnet1_1_1 [N30UH_20C] = polyline(z=0mm, xy in mm: (-50.4972, 0.5263) (-50.4593, 2.0258) (-53.4587, 2.1016) (-53.4966, 0.6021) (-50.4972, 0.5263), closed, covered)
  Stator_Lamination_Primitive [M350-50A_20C] = user_primitive(RMxprt/VentSlotCore.dll, DiaGap=DiaGap, DiaYoke=DiaStatorYoke, Length=Stator_Lam_Length, Skew=StatorSkewAngle, Slots=SlotNumber_Stator, SlotType=SlotType_Stator, Hs0=Hs0_Stator, Hs01=0mm, Hs1=Hs1_Stator, Hs2=8.8385619mm, Bs0=Bs0_Stator, Bs1=5.9676549mm, Bs2=4.4211069mm, Rs=Rs_Stator, FilletType=FilletType_Stator, HalfSlot=0, VentHoles=0, HoleDiaIn=0mm, HoleDiaOut=0mm, HoleLocIn=0mm, HoleLocOut=0mm, VentDucts=0, DuctWidth=0mm, DuctPitch=0mm, SegAngle=SegAngle, LenRegion=0mm, InfoCore=0)
  2Magnet1_1 [N30UH_20C] = polyline(z=0mm, xy in mm: (-52.9888, -7.3778) (-50.0116, -7.0057) (-50.1976, -5.5173) (-53.1748, -5.8894) (-52.9888, -7.3778), closed, covered)
  2Magnet1_2 [N30UH_20C] = polyline(z=0mm, xy in mm: (-49.8547, 8.0466) (-49.5938, 9.5238) (-52.5483, 10.0458) (-52.8093, 8.5686) (-49.8547, 8.0466), closed, covered)
  2Magnet1_3 [N30UH_20C] = polyline(z=0mm, xy in mm: (-51.2973, -15.1929) (-48.4089, -14.3813) (-48.8147, -12.9373) (-51.7031, -13.7489) (-51.2973, -15.1929), closed, covered)
  2Magnet1_4 [N30UH_20C] = polyline(z=0mm, xy in mm: (-48.0986, 15.3872) (-47.6204, 16.809) (-50.4642, 17.7655) (-50.9424, 16.3438) (-48.0986, 15.3872), closed, covered)
  2Magnet1_5 [N30UH_20C] = polyline(z=0mm, xy in mm: (-48.46, -22.6687) (-45.7248, -21.4357) (-46.3412, -20.0682) (-49.0765, -21.3013) (-48.46, -22.6687), closed, covered)
  2Magnet1_6 [N30UH_20C] = polyline(z=0mm, xy in mm: (-45.268, 22.3841) (-44.5833, 23.7187) (-47.2527, 25.0884) (-47.9375, 23.7538) (-45.268, 22.3841), closed, covered)
  2Magnet1_7 [N30UH_20C] = polyline(z=0mm, xy in mm: (-44.5401, -29.6381) (-42.0192, -28.0112) (-42.8326, -26.7509) (-45.3535, -28.3778) (-44.5401, -29.6381), closed, covered)
  2Magnet1_8 [N30UH_20C] = polyline(z=0mm, xy in mm: (-41.4262, 28.8809) (-40.5502, 30.0986) (-42.9857, 31.8508) (-43.8617, 30.6332) (-41.4262, 28.8809), closed, covered)
  2Magnet1_9 [N30UH_20C] = polyline(z=0mm, xy in mm: (-39.6253, -35.9455) (-37.3751, -33.961) (-38.3672, -32.836) (-40.6175, -34.8205) (-39.6253, -35.9455), closed, covered)
  2Magnet1_10 [N30UH_20C] = polyline(z=0mm, xy in mm: (-37.7584, 37.9017) (-38.8062, 36.8283) (-36.6591, 34.7326) (-35.6113, 35.8061) (-37.7584, 37.9017), closed, covered)
  2Magnet1_11 [N30UH_20C] = polyline(z=0mm, xy in mm: (-33.8253, -41.4498) (-31.896, -39.1521) (-33.0447, -38.1876) (-34.9741, -40.4853) (-33.8253, -41.4498), closed, covered)
  2Magnet1_12 [N30UH_20C] = polyline(z=0mm, xy in mm: (-31.073, 39.8085) (-29.877, 40.7138) (-31.6877, 43.106) (-32.8838, 42.2007) (-31.073, 39.8085), closed, covered)
  2Magnet1_13 [N30UH_20C] = polyline(z=0mm, xy in mm: (-27.2697, -46.0283) (-25.7044, -43.4687) (-26.9841, -42.6861) (-28.5494, -45.2457) (-27.2697, -46.0283), closed, covered)
  2Magnet1_14 [N30UH_20C] = polyline(z=0mm, xy in mm: (-24.7928, 43.995) (-23.4752, 44.712) (-24.9092, 47.3474) (-26.2268, 46.6305) (-24.7928, 43.995), closed, covered)
  2Magnet1_15 [N30UH_20C] = polyline(z=0mm, xy in mm: (-20.105, -49.5785) (-18.9386, -46.8142) (-20.3206, -46.2311) (-21.487, -48.9954) (-20.105, -49.5785), closed, covered)
  2Magnet1_16 [N30UH_20C] = polyline(z=0mm, xy in mm: (-17.9587, 47.1988) (-16.549, 47.7114) (-17.5742, 50.5311) (-18.9839, 50.0185) (-17.9587, 47.1988), closed, covered)
  2Magnet1_17 [N30UH_20C] = polyline(z=0mm, xy in mm: (-12.4911, -52.0213) (-11.7498, -49.114) (-13.2033, -48.7434) (-13.9446, -51.6507) (-12.4911, -52.0213), closed, covered)
  2Magnet1_18 [N30UH_20C] = polyline(z=0mm, xy in mm: (-10.7235, 49.3483) (-9.2532, 49.645) (-9.8466, 52.586) (-11.317, 52.2893) (-10.7235, 49.3483), closed, covered)
  2Magnet1_19 [N30UH_20C] = polyline(z=0mm, xy in mm: (-4.5982, -53.302) (-4.2985, -50.3167) (-5.791, -50.1668) (-6.0907, -53.1521) (-4.5982, -53.302), closed, covered)
  2Magnet1_20 [N30UH_20C] = polyline(z=0mm, xy in mm: (-3.2488, 50.3953) (-1.7506, 50.4696) (-1.8991, 53.4662) (-3.3973, 53.392) (-3.2488, 50.3953), closed, covered)
  2Magnet1_21 [N30UH_20C] = polyline(z=0mm, xy in mm: (3.2488, -50.3953) (1.7506, -50.4696) (1.8991, -53.4662) (3.3973, -53.392) (3.2488, -50.3953), closed, covered)
  2Magnet1_22 [N30UH_20C] = polyline(z=0mm, xy in mm: (5.791, 50.1668) (6.0907, 53.1521) (4.5982, 53.302) (4.2985, 50.3167) (5.791, 50.1668), closed, covered)
  2Magnet1_23 [N30UH_20C] = polyline(z=0mm, xy in mm: (10.7235, -49.3483) (9.2532, -49.645) (9.8466, -52.586) (11.317, -52.2893) (10.7235, -49.3483), closed, covered)
  2Magnet1_24 [N30UH_20C] = polyline(z=0mm, xy in mm: (13.2033, 48.7434) (13.9446, 51.6507) (12.4911, 52.0213) (11.7498, 49.114) (13.2033, 48.7434), closed, covered)
  2Magnet1_25 [N30UH_20C] = polyline(z=0mm, xy in mm: (17.9587, -47.1988) (16.549, -47.7114) (17.5742, -50.5311) (18.9839, -50.0185) (17.9587, -47.1988), closed, covered)
  2Magnet1_26 [N30UH_20C] = polyline(z=0mm, xy in mm: (20.3206, 46.2311) (21.487, 48.9954) (20.105, 49.5785) (18.9386, 46.8142) (20.3206, 46.2311), closed, covered)
  2Magnet1_27 [N30UH_20C] = polyline(z=0mm, xy in mm: (24.7928, -43.995) (23.4752, -44.712) (24.9092, -47.3474) (26.2268, -46.6305) (24.7928, -43.995), closed, covered)
  2Magnet1_28 [N30UH_20C] = polyline(z=0mm, xy in mm: (27.2697, 46.0283) (25.7044, 43.4687) (26.9841, 42.6861) (28.5494, 45.2457) (27.2697, 46.0283), closed, covered)
  2Magnet1_29 [N30UH_20C] = polyline(z=0mm, xy in mm: (31.073, -39.8085) (29.877, -40.7138) (31.6877, -43.106) (32.8838, -42.2007) (31.073, -39.8085), closed, covered)
  2Magnet1_30 [N30UH_20C] = polyline(z=0mm, xy in mm: (33.8253, 41.4498) (31.896, 39.1521) (33.0447, 38.1876) (34.9741, 40.4853) (33.8253, 41.4498), closed, covered)
  2Magnet1_31 [N30UH_20C] = polyline(z=0mm, xy in mm: (36.6591, -34.7326) (35.6113, -35.8061) (37.7584, -37.9017) (38.8062, -36.8283) (36.6591, -34.7326), closed, covered)
  2Magnet1_32 [N30UH_20C] = polyline(z=0mm, xy in mm: (39.6253, 35.9455) (37.3751, 33.961) (38.3672, 32.836) (40.6175, 34.8205) (39.6253, 35.9455), closed, covered)
  2Magnet1_33 [N30UH_20C] = polyline(z=0mm, xy in mm: (41.4262, -28.8809) (40.5502, -30.0986) (42.9857, -31.8508) (43.8617, -30.6332) (41.4262, -28.8809), closed, covered)
  2Magnet1_34 [N30UH_20C] = polyline(z=0mm, xy in mm: (44.5401, 29.6381) (42.0192, 28.0112) (42.8326, 26.7509) (45.3535, 28.3778) (44.5401, 29.6381), closed, covered)
  2Magnet1_35 [N30UH_20C] = polyline(z=0mm, xy in mm: (45.268, -22.3841) (44.5833, -23.7187) (47.2527, -25.0884) (47.9375, -23.7538) (45.268, -22.3841), closed, covered)
  2Magnet1_36 [N30UH_20C] = polyline(z=0mm, xy in mm: (48.46, 22.6687) (45.7248, 21.4357) (46.3412, 20.0682) (49.0765, 21.3013) (48.46, 22.6687), closed, covered)
  2Magnet1_37 [N30UH_20C] = polyline(z=0mm, xy in mm: (48.0986, -15.3872) (47.6204, -16.809) (50.4642, -17.7655) (50.9424, -16.3438) (48.0986, -15.3872), closed, covered)
  2Magnet1_38 [N30UH_20C] = polyline(z=0mm, xy in mm: (51.2973, 15.1929) (48.4089, 14.3813) (48.8147, 12.9373) (51.7031, 13.7489) (51.2973, 15.1929), closed, covered)
  2Magnet1_39 [N30UH_20C] = polyline(z=0mm, xy in mm: (49.8547, -8.0466) (49.5938, -9.5238) (52.5483, -10.0458) (52.8093, -8.5686) (49.8547, -8.0466), closed, covered)
  2Magnet1_40 [N30UH_20C] = polyline(z=0mm, xy in mm: (50.1976, 5.5173) (53.1748, 5.8894) (52.9888, 7.3778) (50.0116, 7.0057) (50.1976, 5.5173), closed, covered)
  2Magnet1_41 [N30UH_20C] = polyline(z=0mm, xy in mm: (50.4972, -0.5263) (50.4593, -2.0258) (53.4587, -2.1016) (53.4966, -0.6021) (50.4972, -0.5263), closed, covered)
  1Magnet1_1 [N30UH_20C] = polyline(z=0mm, xy in mm: (-50.4354, 2.5516) (-49.9359, 7.5266) (-52.9244, 7.8267) (-53.4239, 2.8517) (-50.4354, 2.5516), closed, covered)
  1Magnet1_2 [N30UH_20C] = polyline(z=0mm, xy in mm: (-51.891, -13.0219) (-48.9468, -12.4278) (-49.9359, -7.5266) (-52.88, -8.1207) (-51.891, -13.0219), closed, covered)
  1Magnet1_3 [N30UH_20C] = polyline(z=0mm, xy in mm: (-49.4918, 10.0401) (-48.2564, 14.8851) (-51.1667, 15.6272) (-52.4022, 10.7822) (-49.4918, 10.0401), closed, covered)
  1Magnet1_4 [N30UH_20C] = polyline(z=0mm, xy in mm: (-49.3706, -20.6104) (-46.5479, -19.5841) (-48.2564, -14.8851) (-51.0791, -15.9114) (-49.3706, -20.6104), closed, covered)
  1Magnet1_5 [N30UH_20C] = polyline(z=0mm, xy in mm: (-47.4426, 17.3044) (-45.4989, 21.9111) (-48.2661, 23.0787) (-50.2099, 18.472) (-47.4426, 17.3044), closed, covered)
  1Magnet1_6 [N30UH_20C] = polyline(z=0mm, xy in mm: (-45.7473, -27.7385) (-43.1091, -26.303) (-45.4989, -21.9111) (-48.1371, -23.3466) (-45.7473, -27.7385), closed, covered)
  1Magnet1_7 [N30UH_20C] = polyline(z=0mm, xy in mm: (-44.3336, 24.182) (-41.725, 28.4476) (-44.2873, 30.0146) (-46.8959, 25.749) (-44.3336, 24.182), closed, covered)
  1Magnet1_8 [N30UH_20C] = polyline(z=0mm, xy in mm: (-41.1021, -34.247) (-38.7073, -32.4343) (-41.725, -28.4476) (-44.1198, -30.2603) (-41.1021, -34.247), closed, covered)
  1Magnet1_9 [N30UH_20C] = polyline(z=0mm, xy in mm: (-40.2343, 30.5195) (-37.0191, 34.3487) (-39.3192, 36.2801) (-42.5345, 32.4509) (-40.2343, 30.5195), closed, covered)
  1Magnet1_10 [N30UH_20C] = polyline(z=0mm, xy in mm: (-35.5388, -39.9905) (-33.4409, -37.8411) (-37.0191, -34.3487) (-39.1169, -36.498) (-35.5388, -39.9905), closed, covered)
  1Magnet1_11 [N30UH_20C] = polyline(z=0mm, xy in mm: (-35.2362, 36.1753) (-31.4862, 39.4824) (-33.4728, 41.7351) (-37.2228, 38.4279) (-35.2362, 36.1753), closed, covered)
  1Magnet1_12 [N30UH_20C] = polyline(z=0mm, xy in mm: (-29.1816, -44.8406) (-27.4275, -42.4025) (-31.4862, -39.4824) (-33.2403, -41.9205) (-29.1816, -44.8406), closed, covered)
  1Magnet1_13 [N30UH_20C] = polyline(z=0mm, xy in mm: (-29.451, 41.0229) (-25.2499, 43.7342) (-26.8786, 46.2578) (-31.0797, 43.5465) (-29.451, 41.0229), closed, covered)
  1Magnet1_14 [N30UH_20C] = polyline(z=0mm, xy in mm: (-22.1725, -48.689) (-20.8014, -46.0168) (-25.25, -43.7342) (-26.6211, -46.4065) (-22.1725, -48.689), closed, covered)
  1Magnet1_15 [N30UH_20C] = polyline(z=0mm, xy in mm: (-23.0079, 44.9542) (-18.4497, 47.0091) (-19.684, 49.7472) (-24.2423, 47.6923) (-23.0079, 44.9542), closed, covered)
  1Magnet1_16 [N30UH_20C] = polyline(z=0mm, xy in mm: (-14.6681, -51.4499) (-13.7106, -48.6031) (-18.4497, -47.0091) (-19.4072, -49.8558) (-14.6681, -51.4499), closed, covered)
  1Magnet1_17 [N30UH_20C] = polyline(z=0mm, xy in mm: (-16.0508, 47.8813) (-11.2373, 49.2338) (-12.0497, 52.1253) (-16.8633, 50.7727) (-16.0508, 47.8813), closed, covered)
  1Magnet1_18 [N30UH_20C] = polyline(z=0mm, xy in mm: (-6.8361, -53.0614) (-6.3135, -50.1037) (-11.2373, -49.2338) (-11.7598, -52.1915) (-6.8361, -53.0614), closed, covered)
  1Magnet1_19 [N30UH_20C] = polyline(z=0mm, xy in mm: (-8.7352, 49.7387) (-3.7738, 50.3587) (-4.1463, 53.339) (-9.1077, 52.719) (-8.7352, 49.7387), closed, covered)
  1Magnet1_20 [N30UH_20C] = polyline(z=0mm, xy in mm: (1.1486, -53.4876) (1.2245, -50.4851) (-3.7738, -50.3587) (-3.8497, -53.3613) (1.1486, -53.4876), closed, covered)
  1Magnet1_21 [N30UH_20C] = polyline(z=0mm, xy in mm: (-1.1486, 53.4876) (-1.2245, 50.4851) (3.7738, 50.3587) (3.8497, 53.3613) (-1.1486, 53.4876), closed, covered)
  1Magnet1_22 [N30UH_20C] = polyline(z=0mm, xy in mm: (8.7352, -49.7387) (3.7738, -50.3587) (4.1463, -53.339) (9.1077, -52.719) (8.7352, -49.7387), closed, covered)
  1Magnet1_23 [N30UH_20C] = polyline(z=0mm, xy in mm: (11.2373, 49.2338) (11.7598, 52.1915) (6.8361, 53.0614) (6.3135, 50.1037) (11.2373, 49.2338), closed, covered)
  1Magnet1_24 [N30UH_20C] = polyline(z=0mm, xy in mm: (16.0508, -47.8813) (11.2373, -49.2338) (12.0497, -52.1253) (16.8633, -50.7727) (16.0508, -47.8813), closed, covered)
  1Magnet1_25 [N30UH_20C] = polyline(z=0mm, xy in mm: (18.4497, 47.0091) (19.4072, 49.8558) (14.6681, 51.4499) (13.7106, 48.6031) (18.4497, 47.0091), closed, covered)
  1Magnet1_26 [N30UH_20C] = polyline(z=0mm, xy in mm: (23.0079, -44.9542) (18.4497, -47.0091) (19.684, -49.7472) (24.2423, -47.6923) (23.0079, -44.9542), closed, covered)
  1Magnet1_27 [N30UH_20C] = polyline(z=0mm, xy in mm: (22.1725, 48.689) (20.8014, 46.0168) (25.25, 43.7342) (26.6211, 46.4065) (22.1725, 48.689), closed, covered)
  1Magnet1_28 [N30UH_20C] = polyline(z=0mm, xy in mm: (29.451, -41.0229) (25.25, -43.7342) (26.8786, -46.2578) (31.0797, -43.5465) (29.451, -41.0229), closed, covered)
  1Magnet1_29 [N30UH_20C] = polyline(z=0mm, xy in mm: (31.4862, 39.4824) (33.2403, 41.9205) (29.1816, 44.8406) (27.4275, 42.4025) (31.4862, 39.4824), closed, covered)
  1Magnet1_30 [N30UH_20C] = polyline(z=0mm, xy in mm: (35.2362, -36.1753) (31.4862, -39.4824) (33.4728, -41.7351) (37.2228, -38.4279) (35.2362, -36.1753), closed, covered)
  1Magnet1_31 [N30UH_20C] = polyline(z=0mm, xy in mm: (35.5388, 39.9905) (33.4409, 37.8411) (37.0191, 34.3487) (39.1169, 36.498) (35.5388, 39.9905), closed, covered)
  1Magnet1_32 [N30UH_20C] = polyline(z=0mm, xy in mm: (40.2343, -30.5195) (37.0191, -34.3487) (39.3192, -36.2801) (42.5345, -32.4509) (40.2343, -30.5195), closed, covered)
  1Magnet1_33 [N30UH_20C] = polyline(z=0mm, xy in mm: (41.725, 28.4476) (44.1198, 30.2603) (41.1021, 34.247) (38.7073, 32.4343) (41.725, 28.4476), closed, covered)
  1Magnet1_34 [N30UH_20C] = polyline(z=0mm, xy in mm: (44.3336, -24.182) (41.725, -28.4476) (44.2873, -30.0146) (46.8959, -25.749) (44.3336, -24.182), closed, covered)
  1Magnet1_35 [N30UH_20C] = polyline(z=0mm, xy in mm: (45.4989, 21.9111) (48.1371, 23.3466) (45.7473, 27.7385) (43.1091, 26.303) (45.4989, 21.9111), closed, covered)
  1Magnet1_36 [N30UH_20C] = polyline(z=0mm, xy in mm: (47.4426, -17.3044) (45.4989, -21.9111) (48.2661, -23.0787) (50.2099, -18.472) (47.4426, -17.3044), closed, covered)
  1Magnet1_37 [N30UH_20C] = polyline(z=0mm, xy in mm: (48.2564, 14.8851) (51.0791, 15.9114) (49.3706, 20.6104) (46.5479, 19.5841) (48.2564, 14.8851), closed, covered)
  1Magnet1_38 [N30UH_20C] = polyline(z=0mm, xy in mm: (49.4918, -10.0401) (48.2564, -14.8851) (51.1667, -15.6272) (52.4022, -10.7822) (49.4918, -10.0401), closed, covered)
  1Magnet1_39 [N30UH_20C] = polyline(z=0mm, xy in mm: (49.9359, 7.5266) (52.88, 8.1207) (51.891, 13.0219) (48.9468, 12.4278) (49.9359, 7.5266), closed, covered)
  1Magnet1_40 [N30UH_20C] = polyline(z=0mm, xy in mm: (50.4354, -2.5516) (49.9359, -7.5266) (52.9244, -7.8267) (53.4239, -2.8517) (50.4354, -2.5516), closed, covered)
  1Magnet1_41 [N30UH_20C] = polyline(z=0mm, xy in mm: (50.5, 0) (53.4997, 0.1486) (53.2522, 5.1425) (50.2524, 4.9938) (50.5, 0), closed, covered)
  Rotor_1.move(0mm, 0mm, 5mm)
  Rotor_1.sweep_along_vector((0mm, 0mm, -10mm))
  Ph1_P1_C9 [Copper (Annealed)_40C] = user_primitive(RMxprt/LapCoil.dll, DiaGap=100mm, DiaYoke=DiaStatorYoke, Length=Stator_Lam_Length, Skew=StatorSkewAngle, Slots=SlotNumber_Stator, SlotType=SlotType_Stator, Hs0=Hs0_Stator, Hs1=Hs1_Stator, Hs2=8.8385619mm, Bs0=Bs0_Stator, Bs1=5.9676549mm, Bs2=4.4211069mm, Rs=Rs_Stator, FilletType=FilletType_Stator, Layers=Layers, CoilPitch=1, EndExt=WdgExt_Avg, SpanExt=SpanExt, BendAngle=0deg, SegAngle=SegAngle_Coil_Armature, LenRegion=Model_Length, InfoCoil=1)
  Ph1_P1_C9.rotate(axis=Z, angle=100deg)
  Ph1_P1_C10 [Copper (Annealed)_40C] = user_primitive(RMxprt/LapCoil.dll, DiaGap=100mm, DiaYoke=DiaStatorYoke, Length=Stator_Lam_Length, Skew=StatorSkewAngle, Slots=SlotNumber_Stator, SlotType=SlotType_Stator, Hs0=Hs0_Stator, Hs1=Hs1_Stator, Hs2=8.8385619mm, Bs0=Bs0_Stator, Bs1=5.9676549mm, Bs2=4.4211069mm, Rs=Rs_Stator, FilletType=FilletType_Stator, Layers=Layers, CoilPitch=1, EndExt=WdgExt_Avg, SpanExt=SpanExt, BendAngle=0deg, SegAngle=SegAngle_Coil_Armature, LenRegion=Model_Length, InfoCoil=1)
  Ph1_P1_C10.rotate(axis=Z, angle=90deg)
  Ph1_P1_C11 [Copper (Annealed)_40C] = user_primitive(RMxprt/LapCoil.dll, DiaGap=100mm, DiaYoke=DiaStatorYoke, Length=Stator_Lam_Length, Skew=StatorSkewAngle, Slots=SlotNumber_Stator, SlotType=SlotType_Stator, Hs0=Hs0_Stator, Hs1=Hs1_Stator, Hs2=8.8385619mm, Bs0=Bs0_Stator, Bs1=5.9676549mm, Bs2=4.4211069mm, Rs=Rs_Stator, FilletType=FilletType_Stator, Layers=Layers, CoilPitch=1, EndExt=WdgExt_Avg, SpanExt=SpanExt, BendAngle=0deg, SegAngle=SegAngle_Coil_Armature, LenRegion=Model_Length, InfoCoil=1)
  Ph1_P1_C11.rotate(axis=Z, angle=40deg)
  Ph1_P1_C12 [Copper (Annealed)_40C] = user_primitive(RMxprt/LapCoil.dll, DiaGap=100mm, DiaYoke=DiaStatorYoke, Length=Stator_Lam_Length, Skew=StatorSkewAngle, Slots=SlotNumber_Stator, SlotType=SlotType_Stator, Hs0=Hs0_Stator, Hs1=Hs1_Stator, Hs2=8.8385619mm, Bs0=Bs0_Stator, Bs1=5.9676549mm, Bs2=4.4211069mm, Rs=Rs_Stator, FilletType=FilletType_Stator, Layers=Layers, CoilPitch=1, EndExt=WdgExt_Avg, SpanExt=SpanExt, BendAngle=0deg, SegAngle=SegAngle_Coil_Armature, LenRegion=Model_Length, InfoCoil=1)
  Ph1_P1_C12.rotate(axis=Z, angle=30deg)
  Ph2_P1_C8 [Copper (Annealed)_40C] = user_primitive(RMxprt/LapCoil.dll, DiaGap=100mm, DiaYoke=DiaStatorYoke, Length=Stator_Lam_Length, Skew=StatorSkewAngle, Slots=SlotNumber_Stator, SlotType=SlotType_Stator, Hs0=Hs0_Stator, Hs1=Hs1_Stator, Hs2=8.8385619mm, Bs0=Bs0_Stator, Bs1=5.9676549mm, Bs2=4.4211069mm, Rs=Rs_Stator, FilletType=FilletType_Stator, Layers=Layers, CoilPitch=1, EndExt=WdgExt_Avg, SpanExt=SpanExt, BendAngle=0deg, SegAngle=SegAngle_Coil_Armature, LenRegion=Model_Length, InfoCoil=1)
  Ph2_P1_C8.rotate(axis=Z, angle=110deg)
  Ph2_P1_C9 [Copper (Annealed)_40C] = user_primitive(RMxprt/LapCoil.dll, DiaGap=100mm, DiaYoke=DiaStatorYoke, Length=Stator_Lam_Length, Skew=StatorSkewAngle, Slots=SlotNumber_Stator, SlotType=SlotType_Stator, Hs0=Hs0_Stator, Hs1=Hs1_Stator, Hs2=8.8385619mm, Bs0=Bs0_Stator, Bs1=5.9676549mm, Bs2=4.4211069mm, Rs=Rs_Stator, FilletType=FilletType_Stator, Layers=Layers, CoilPitch=1, EndExt=WdgExt_Avg, SpanExt=SpanExt, BendAngle=0deg, SegAngle=SegAngle_Coil_Armature, LenRegion=Model_Length, InfoCoil=1)
  Ph2_P1_C9.rotate(axis=Z, angle=60deg)
  Ph2_P1_C10 [Copper (Annealed)_40C] = user_primitive(RMxprt/LapCoil.dll, DiaGap=100mm, DiaYoke=DiaStatorYoke, Length=Stator_Lam_Length, Skew=StatorSkewAngle, Slots=SlotNumber_Stator, SlotType=SlotType_Stator, Hs0=Hs0_Stator, Hs1=Hs1_Stator, Hs2=8.8385619mm, Bs0=Bs0_Stator, Bs1=5.9676549mm, Bs2=4.4211069mm, Rs=Rs_Stator, FilletType=FilletType_Stator, Layers=Layers, CoilPitch=1, EndExt=WdgExt_Avg, SpanExt=SpanExt, BendAngle=0deg, SegAngle=SegAngle_Coil_Armature, LenRegion=Model_Length, InfoCoil=1)
  Ph2_P1_C10.rotate(axis=Z, angle=50deg)
  Ph2_P1_C11 [Copper (Annealed)_40C] = user_primitive(RMxprt/LapCoil.dll, DiaGap=100mm, DiaYoke=DiaStatorYoke, Length=Stator_Lam_Length, Skew=StatorSkewAngle, Slots=SlotNumber_Stator, SlotType=SlotType_Stator, Hs0=Hs0_Stator, Hs1=Hs1_Stator, Hs2=8.8385619mm, Bs0=Bs0_Stator, Bs1=5.9676549mm, Bs2=4.4211069mm, Rs=Rs_Stator, FilletType=FilletType_Stator, Layers=Layers, CoilPitch=1, EndExt=WdgExt_Avg, SpanExt=SpanExt, BendAngle=0deg, SegAngle=SegAngle_Coil_Armature, LenRegion=Model_Length, InfoCoil=1)
  Ph2_P1_C11.rotate(axis=Z, angle=0deg)
  Ph2_P1_C12 [Copper (Annealed)_40C] = user_primitive(RMxprt/LapCoil.dll, DiaGap=100mm, DiaYoke=DiaStatorYoke, Length=Stator_Lam_Length, Skew=StatorSkewAngle, Slots=SlotNumber_Stator, SlotType=SlotType_Stator, Hs0=Hs0_Stator, Hs1=Hs1_Stator, Hs2=8.8385619mm, Bs0=Bs0_Stator, Bs1=5.9676549mm, Bs2=4.4211069mm, Rs=Rs_Stator, FilletType=FilletType_Stator, Layers=Layers, CoilPitch=1, EndExt=WdgExt_Avg, SpanExt=SpanExt, BendAngle=0deg, SegAngle=SegAngle_Coil_Armature, LenRegion=Model_Length, InfoCoil=1)
  Ph2_P1_C12.rotate(axis=Z, angle=350deg)
  Ph3_P1_C7 [Copper (Annealed)_40C] = user_primitive(RMxprt/LapCoil.dll, DiaGap=100mm, DiaYoke=DiaStatorYoke, Length=Stator_Lam_Length, Skew=StatorSkewAngle, Slots=SlotNumber_Stator, SlotType=SlotType_Stator, Hs0=Hs0_Stator, Hs1=Hs1_Stator, Hs2=8.8385619mm, Bs0=Bs0_Stator, Bs1=5.9676549mm, Bs2=4.4211069mm, Rs=Rs_Stator, FilletType=FilletType_Stator, Layers=Layers, CoilPitch=1, EndExt=WdgExt_Avg, SpanExt=SpanExt, BendAngle=0deg, SegAngle=SegAngle_Coil_Armature, LenRegion=Model_Length, InfoCoil=1)
  Ph3_P1_C7.rotate(axis=Z, angle=80deg)
  Ph3_P1_C8 [Copper (Annealed)_40C] = user_primitive(RMxprt/LapCoil.dll, DiaGap=100mm, DiaYoke=DiaStatorYoke, Length=Stator_Lam_Length, Skew=StatorSkewAngle, Slots=SlotNumber_Stator, SlotType=SlotType_Stator, Hs0=Hs0_Stator, Hs1=Hs1_Stator, Hs2=8.8385619mm, Bs0=Bs0_Stator, Bs1=5.9676549mm, Bs2=4.4211069mm, Rs=Rs_Stator, FilletType=FilletType_Stator, Layers=Layers, CoilPitch=1, EndExt=WdgExt_Avg, SpanExt=SpanExt, BendAngle=0deg, SegAngle=SegAngle_Coil_Armature, LenRegion=Model_Length, InfoCoil=1)
  Ph3_P1_C8.rotate(axis=Z, angle=70deg)
  Ph3_P1_C9 [Copper (Annealed)_40C] = user_primitive(RMxprt/LapCoil.dll, DiaGap=100mm, DiaYoke=DiaStatorYoke, Length=Stator_Lam_Length, Skew=StatorSkewAngle, Slots=SlotNumber_Stator, SlotType=SlotType_Stator, Hs0=Hs0_Stator, Hs1=Hs1_Stator, Hs2=8.8385619mm, Bs0=Bs0_Stator, Bs1=5.9676549mm, Bs2=4.4211069mm, Rs=Rs_Stator, FilletType=FilletType_Stator, Layers=Layers, CoilPitch=1, EndExt=WdgExt_Avg, SpanExt=SpanExt, BendAngle=0deg, SegAngle=SegAngle_Coil_Armature, LenRegion=Model_Length, InfoCoil=1)
  Ph3_P1_C9.rotate(axis=Z, angle=20deg)
  Ph3_P1_C10 [Copper (Annealed)_40C] = user_primitive(RMxprt/LapCoil.dll, DiaGap=100mm, DiaYoke=DiaStatorYoke, Length=Stator_Lam_Length, Skew=StatorSkewAngle, Slots=SlotNumber_Stator, SlotType=SlotType_Stator, Hs0=Hs0_Stator, Hs1=Hs1_Stator, Hs2=8.8385619mm, Bs0=Bs0_Stator, Bs1=5.9676549mm, Bs2=4.4211069mm, Rs=Rs_Stator, FilletType=FilletType_Stator, Layers=Layers, CoilPitch=1, EndExt=WdgExt_Avg, SpanExt=SpanExt, BendAngle=0deg, SegAngle=SegAngle_Coil_Armature, LenRegion=Model_Length, InfoCoil=1)
  Ph3_P1_C10.rotate(axis=Z, angle=10deg)
  coordinate_system PhTerminal_CS = origin=(0mm, 0mm, Stator_Lam_Length/2) Euler Angle ZYZ phi=StatorSkewAngle/2 theta=0deg psi=0deg
  Ph1_P1_C9_Terminal [Copper (Annealed)_40C] = user_primitive(RMxprt/LapCoil.dll, DiaGap=100mm, DiaYoke=DiaStatorYoke, Length=Stator_Lam_Length, Skew=StatorSkewAngle, Slots=SlotNumber_Stator, SlotType=SlotType_Stator, Hs0=Hs0_Stator, Hs1=Hs1_Stator, Hs2=8.8385619mm, Bs0=Bs0_Stator, Bs1=5.9676549mm, Bs2=4.4211069mm, Rs=Rs_Stator, FilletType=FilletType_Stator, Layers=Layers, CoilPitch=1, EndExt=WdgExt_Avg, SpanExt=SpanExt, BendAngle=0deg, SegAngle=SegAngle_Coil_Armature, LenRegion=Model_Length, InfoCoil=3) in PhTerminal_CS
  Ph1_P1_C9_Terminal.rotate(axis=Z, angle=100deg) in PhTerminal_CS
  Ph1_P1_C10_Terminal [Copper (Annealed)_40C] = user_primitive(RMxprt/LapCoil.dll, DiaGap=100mm, DiaYoke=DiaStatorYoke, Length=Stator_Lam_Length, Skew=StatorSkewAngle, Slots=SlotNumber_Stator, SlotType=SlotType_Stator, Hs0=Hs0_Stator, Hs1=Hs1_Stator, Hs2=8.8385619mm, Bs0=Bs0_Stator, Bs1=5.9676549mm, Bs2=4.4211069mm, Rs=Rs_Stator, FilletType=FilletType_Stator, Layers=Layers, CoilPitch=1, EndExt=WdgExt_Avg, SpanExt=SpanExt, BendAngle=0deg, SegAngle=SegAngle_Coil_Armature, LenRegion=Model_Length, InfoCoil=2) in PhTerminal_CS
  Ph1_P1_C10_Terminal.rotate(axis=Z, angle=90deg) in PhTerminal_CS
  Ph1_P1_C11_Terminal [Copper (Annealed)_40C] = user_primitive(RMxprt/LapCoil.dll, DiaGap=100mm, DiaYoke=DiaStatorYoke, Length=Stator_Lam_Length, Skew=StatorSkewAngle, Slots=SlotNumber_Stator, SlotType=SlotType_Stator, Hs0=Hs0_Stator, Hs1=Hs1_Stator, Hs2=8.8385619mm, Bs0=Bs0_Stator, Bs1=5.9676549mm, Bs2=4.4211069mm, Rs=Rs_Stator, FilletType=FilletType_Stator, Layers=Layers, CoilPitch=1, EndExt=WdgExt_Avg, SpanExt=SpanExt, BendAngle=0deg, SegAngle=SegAngle_Coil_Armature, LenRegion=Model_Length, InfoCoil=2) in PhTerminal_CS
  Ph1_P1_C11_Terminal.rotate(axis=Z, angle=40deg) in PhTerminal_CS
  Ph1_P1_C12_Terminal [Copper (Annealed)_40C] = user_primitive(RMxprt/LapCoil.dll, DiaGap=100mm, DiaYoke=DiaStatorYoke, Length=Stator_Lam_Length, Skew=StatorSkewAngle, Slots=SlotNumber_Stator, SlotType=SlotType_Stator, Hs0=Hs0_Stator, Hs1=Hs1_Stator, Hs2=8.8385619mm, Bs0=Bs0_Stator, Bs1=5.9676549mm, Bs2=4.4211069mm, Rs=Rs_Stator, FilletType=FilletType_Stator, Layers=Layers, CoilPitch=1, EndExt=WdgExt_Avg, SpanExt=SpanExt, BendAngle=0deg, SegAngle=SegAngle_Coil_Armature, LenRegion=Model_Length, InfoCoil=3) in PhTerminal_CS
  Ph1_P1_C12_Terminal.rotate(axis=Z, angle=30deg) in PhTerminal_CS
  Ph2_P1_C9_Terminal [Copper (Annealed)_40C] = user_primitive(RMxprt/LapCoil.dll, DiaGap=100mm, DiaYoke=DiaStatorYoke, Length=Stator_Lam_Length, Skew=StatorSkewAngle, Slots=SlotNumber_Stator, SlotType=SlotType_Stator, Hs0=Hs0_Stator, Hs1=Hs1_Stator, Hs2=8.8385619mm, Bs0=Bs0_Stator, Bs1=5.9676549mm, Bs2=4.4211069mm, Rs=Rs_Stator, FilletType=FilletType_Stator, Layers=Layers, CoilPitch=1, EndExt=WdgExt_Avg, SpanExt=SpanExt, BendAngle=0deg, SegAngle=SegAngle_Coil_Armature, LenRegion=Model_Length, InfoCoil=3) in PhTerminal_CS
  Ph2_P1_C9_Terminal.rotate(axis=Z, angle=60deg) in PhTerminal_CS
  Ph2_P1_C10_Terminal [Copper (Annealed)_40C] = user_primitive(RMxprt/LapCoil.dll, DiaGap=100mm, DiaYoke=DiaStatorYoke, Length=Stator_Lam_Length, Skew=StatorSkewAngle, Slots=SlotNumber_Stator, SlotType=SlotType_Stator, Hs0=Hs0_Stator, Hs1=Hs1_Stator, Hs2=8.8385619mm, Bs0=Bs0_Stator, Bs1=5.9676549mm, Bs2=4.4211069mm, Rs=Rs_Stator, FilletType=FilletType_Stator, Layers=Layers, CoilPitch=1, EndExt=WdgExt_Avg, SpanExt=SpanExt, BendAngle=0deg, SegAngle=SegAngle_Coil_Armature, LenRegion=Model_Length, InfoCoil=2) in PhTerminal_CS
  Ph2_P1_C10_Terminal.rotate(axis=Z, angle=50deg) in PhTerminal_CS
  Ph2_P1_C11_Terminal [Copper (Annealed)_40C] = user_primitive(RMxprt/LapCoil.dll, DiaGap=100mm, DiaYoke=DiaStatorYoke, Length=Stator_Lam_Length, Skew=StatorSkewAngle, Slots=SlotNumber_Stator, SlotType=SlotType_Stator, Hs0=Hs0_Stator, Hs1=Hs1_Stator, Hs2=8.8385619mm, Bs0=Bs0_Stator, Bs1=5.9676549mm, Bs2=4.4211069mm, Rs=Rs_Stator, FilletType=FilletType_Stator, Layers=Layers, CoilPitch=1, EndExt=WdgExt_Avg, SpanExt=SpanExt, BendAngle=0deg, SegAngle=SegAngle_Coil_Armature, LenRegion=Model_Length, InfoCoil=2) in PhTerminal_CS
  Ph2_P1_C11_Terminal.rotate(axis=Z, angle=0deg) in PhTerminal_CS
  Ph2_P1_C12_Terminal [Copper (Annealed)_40C] = user_primitive(RMxprt/LapCoil.dll, DiaGap=100mm, DiaYoke=DiaStatorYoke, Length=Stator_Lam_Length, Skew=StatorSkewAngle, Slots=SlotNumber_Stator, SlotType=SlotType_Stator, Hs0=Hs0_Stator, Hs1=Hs1_Stator, Hs2=8.8385619mm, Bs0=Bs0_Stator, Bs1=5.9676549mm, Bs2=4.4211069mm, Rs=Rs_Stator, FilletType=FilletType_Stator, Layers=Layers, CoilPitch=1, EndExt=WdgExt_Avg, SpanExt=SpanExt, BendAngle=0deg, SegAngle=SegAngle_Coil_Armature, LenRegion=Model_Length, InfoCoil=3) in PhTerminal_CS
  Ph2_P1_C12_Terminal.rotate(axis=Z, angle=350deg) in PhTerminal_CS
  Ph3_P1_C7_Terminal [Copper (Annealed)_40C] = user_primitive(RMxprt/LapCoil.dll, DiaGap=100mm, DiaYoke=DiaStatorYoke, Length=Stator_Lam_Length, Skew=StatorSkewAngle, Slots=SlotNumber_Stator, SlotType=SlotType_Stator, Hs0=Hs0_Stator, Hs1=Hs1_Stator, Hs2=8.8385619mm, Bs0=Bs0_Stator, Bs1=5.9676549mm, Bs2=4.4211069mm, Rs=Rs_Stator, FilletType=FilletType_Stator, Layers=Layers, CoilPitch=1, EndExt=WdgExt_Avg, SpanExt=SpanExt, BendAngle=0deg, SegAngle=SegAngle_Coil_Armature, LenRegion=Model_Length, InfoCoil=2) in PhTerminal_CS
  Ph3_P1_C7_Terminal.rotate(axis=Z, angle=80deg) in PhTerminal_CS
  Ph3_P1_C8_Terminal [Copper (Annealed)_40C] = user_primitive(RMxprt/LapCoil.dll, DiaGap=100mm, DiaYoke=DiaStatorYoke, Length=Stator_Lam_Length, Skew=StatorSkewAngle, Slots=SlotNumber_Stator, SlotType=SlotType_Stator, Hs0=Hs0_Stator, Hs1=Hs1_Stator, Hs2=8.8385619mm, Bs0=Bs0_Stator, Bs1=5.9676549mm, Bs2=4.4211069mm, Rs=Rs_Stator, FilletType=FilletType_Stator, Layers=Layers, CoilPitch=1, EndExt=WdgExt_Avg, SpanExt=SpanExt, BendAngle=0deg, SegAngle=SegAngle_Coil_Armature, LenRegion=Model_Length, InfoCoil=3) in PhTerminal_CS
  Ph3_P1_C8_Terminal.rotate(axis=Z, angle=70deg) in PhTerminal_CS
  Ph3_P1_C9_Terminal [Copper (Annealed)_40C] = user_primitive(RMxprt/LapCoil.dll, DiaGap=100mm, DiaYoke=DiaStatorYoke, Length=Stator_Lam_Length, Skew=StatorSkewAngle, Slots=SlotNumber_Stator, SlotType=SlotType_Stator, Hs0=Hs0_Stator, Hs1=Hs1_Stator, Hs2=8.8385619mm, Bs0=Bs0_Stator, Bs1=5.9676549mm, Bs2=4.4211069mm, Rs=Rs_Stator, FilletType=FilletType_Stator, Layers=Layers, CoilPitch=1, EndExt=WdgExt_Avg, SpanExt=SpanExt, BendAngle=0deg, SegAngle=SegAngle_Coil_Armature, LenRegion=Model_Length, InfoCoil=3) in PhTerminal_CS
  Ph3_P1_C9_Terminal.rotate(axis=Z, angle=20deg) in PhTerminal_CS
  Ph3_P1_C10_Terminal [Copper (Annealed)_40C] = user_primitive(RMxprt/LapCoil.dll, DiaGap=100mm, DiaYoke=DiaStatorYoke, Length=Stator_Lam_Length, Skew=StatorSkewAngle, Slots=SlotNumber_Stator, SlotType=SlotType_Stator, Hs0=Hs0_Stator, Hs1=Hs1_Stator, Hs2=8.8385619mm, Bs0=Bs0_Stator, Bs1=5.9676549mm, Bs2=4.4211069mm, Rs=Rs_Stator, FilletType=FilletType_Stator, Layers=Layers, CoilPitch=1, EndExt=WdgExt_Avg, SpanExt=SpanExt, BendAngle=0deg, SegAngle=SegAngle_Coil_Armature, LenRegion=Model_Length, InfoCoil=2) in PhTerminal_CS
  Ph3_P1_C10_Terminal.rotate(axis=Z, angle=10deg) in PhTerminal_CS
  1Magnet1_1_1.move(0mm, 0mm, Magnet_Length/2+Magnet_Axial_Offset) in PhTerminal_CS
  1Magnet1_1_1.sweep_along_vector((0mm, 0mm, -10mm)) in PhTerminal_CS
  2Magnet1_1_1.move(0mm, 0mm, Magnet_Length/2+Magnet_Axial_Offset) in PhTerminal_CS
  2Magnet1_1_1.sweep_along_vector((0mm, 0mm, -10mm)) in PhTerminal_CS
boundaries and excitations:
  CT_Ph1_P1_C9: Coil Terminal Objects=Ph1_P1_C9_Terminal Conductor_number=6 Winding=WG_Ph1_P1 Point_out_of_terminal=false
  CT_Ph1_P1_C10: Coil Terminal Objects=Ph1_P1_C10_Terminal Conductor_number=6 Winding=WG_Ph1_P1 Point_out_of_terminal=false
  CT_Ph1_P1_C11: Coil Terminal Objects=Ph1_P1_C11_Terminal Conductor_number=6 Winding=WG_Ph1_P1 Point_out_of_terminal=false
  CT_Ph1_P1_C12: Coil Terminal Objects=Ph1_P1_C12_Terminal Conductor_number=6 Winding=WG_Ph1_P1 Point_out_of_terminal=false
  CT_Ph2_P1_C9: Coil Terminal Objects=Ph2_P1_C9_Terminal Conductor_number=6 Winding=WG_Ph2_P1 Point_out_of_terminal=false
  CT_Ph2_P1_C10: Coil Terminal Objects=Ph2_P1_C10_Terminal Conductor_number=6 Winding=WG_Ph2_P1 Point_out_of_terminal=false
  CT_Ph2_P1_C11: Coil Terminal Objects=Ph2_P1_C11_Terminal Conductor_number=6 Winding=WG_Ph2_P1 Point_out_of_terminal=false
  CT_Ph2_P1_C12: Coil Terminal Objects=Ph2_P1_C12_Terminal Conductor_number=6 Winding=WG_Ph2_P1 Point_out_of_terminal=false
  CT_Ph3_P1_C7: Coil Terminal Objects=Ph3_P1_C7_Terminal Conductor_number=6 Winding=WG_Ph3_P1 Point_out_of_terminal=false
  CT_Ph3_P1_C8: Coil Terminal Objects=Ph3_P1_C8_Terminal Conductor_number=6 Winding=WG_Ph3_P1 Point_out_of_terminal=false
  CT_Ph3_P1_C9: Coil Terminal Objects=Ph3_P1_C9_Terminal Conductor_number=6 Winding=WG_Ph3_P1 Point_out_of_terminal=false
  CT_Ph3_P1_C10: Coil Terminal Objects=Ph3_P1_C10_Terminal Conductor_number=6 Winding=WG_Ph3_P1 Point_out_of_terminal=false
  WG_Ph1_P1: Winding Group Type=Current IsSolid=false Current="IPeak * sin((pi * MachineRPM/1rpm*NumPoles / 60*time + (360 - 0) / 360 * 2 * pi) + PhaseAdvance )" ParallelBranchesNum=ParallelPaths
  WG_Ph2_P1: Winding Group Type=Current IsSolid=false Current="IPeak * sin((pi * MachineRPM/1rpm*NumPoles / 60*time + (360 - 120) / 360 * 2 * pi) + PhaseAdvance )" ParallelBranchesNum=ParallelPaths
  WG_Ph3_P1: Winding Group Type=Current IsSolid=false Current="IPeak * sin((pi * MachineRPM/1rpm*NumPoles / 60*time + (360 - 240) / 360 * 2 * pi) + PhaseAdvance )" ParallelBranchesNum=ParallelPaths
mesh:
  initial mesh: GlobalCurvilinear{Apply}
